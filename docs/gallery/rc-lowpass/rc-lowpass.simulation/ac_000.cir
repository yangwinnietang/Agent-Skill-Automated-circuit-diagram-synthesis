rc-lowpass: RC low-pass filter
* Ideal linear signal model; opamps have no supply or output limits.
V1 vin 0 DC 1 AC 1
R1 vin out 1000
C1 out 0 9.9999999999999995e-08
.ac lin 1 100 100
.control
set filetype=ascii
set numdgt=15
run
write result.raw all
quit
.endc
.end
