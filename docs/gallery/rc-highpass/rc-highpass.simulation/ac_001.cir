rc-highpass: RC high-pass filter
* Ideal linear signal model; opamps have no supply or output limits.
V1 vin 0 DC 1 AC 1
C1 vin out 9.9999999999999995e-08
R1 out 0 1000
.ac lin 1 1591.5494309189537 1591.5494309189537
.control
set filetype=ascii
set numdgt=15
run
write result.raw all
quit
.endc
.end
